* milsblo 5V rail output ripple
* AP63205WU-7, 12V to fixed 5.0V, 4.7uH inductor
*
* The AP63205 has no public SPICE model, so regulation and load-step response
* are not simulated. FB senses the output directly, so the datasheet holds VOUT
* at 4.95-5.05V at the output pin, including the drop across the inductor DCR.
* This netlist covers the one quantity the passives set: ripple in the output
* capacitor.
*
* Design values (Diodes Inc. DS41326 Rev. 3-2):
*   Vin  = 12V, Vout = 5.0V, D = 5/12 = 0.4167
*   Fsw  = 1.1MHz, T = 909.09ns, t_on = 378.8ns (minimum on time is 80ns)
*   L1   = 4.7uH, CENKER CKCS4018-4.7uH/M, C354574 (Isat 1.7A, rated 1.2A)
*   Cout = 22uF ceramic, ESR 3mOhm, nominal capacitance with no DC-bias derating
*
* Analytical check:
*   dIL     = (12-5) * 0.4167 / (1.1M * 4.7u) = 0.564A pk-pk
*   IL_peak = 500mA + 282mA = 782mA at the 500mA ESP32 peak, below Isat
*   dV_cap  = 0.564 / (8 * 1.1M * 22u)        = 2.91mV
*   dV_esr  = 0.564 * 3m                      = 1.69mV
*
* The inductor presents 32 Ohm at 1.1MHz, so the AC ripple current flows through
* the capacitor and is modelled as a triangular current source into it.

* One 22uF output capacitor, as on the board
Iripple1  0  VOUT1  PULSE(-0.282 0.282 0 378.8ns 530.3ns 0 909.09ns)
Cout1     VOUT1  VESR1  22uF  IC=0
Resr1     VESR1  0      3m
Rbleed1   VOUT1  0      1Meg

* Two 22uF output capacitors, as in the datasheet's typical circuit
Iripple2  0  VOUT2  PULSE(-0.282 0.282 0 378.8ns 530.3ns 0 909.09ns)
Cout2     VOUT2  VESR2  44uF  IC=0
Resr2     VESR2  0      1.5m
Rbleed2   VOUT2  0      1Meg

.tran 1ns 40us UIC
.save V(VOUT1) V(VOUT2)

.measure tran ripple_1x22uF  PP  V(VOUT1)  FROM=20us  TO=40us
.measure tran ripple_2x22uF  PP  V(VOUT2)  FROM=20us  TO=40us

.end
